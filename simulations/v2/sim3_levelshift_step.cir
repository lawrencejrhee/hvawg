* HVAWG -- SIM 3: level shifter alone -- small-step stability (+/-20 mV DAC steps)
* Run:  LTspice.exe -b sim3_levelshift_step.cir   Results: .meas tables in sim3_levelshift_step.log
* Same run table as sim3_levelshift.cir (1-3: +/-50 V V1 / V2 45p / V2 100p; 4-6: +/-120 V).
* DAC: 0 V -> +20 mV at 2 us (10 ns edge) -> -20 mV at 22 us -> end 42 us.
* TP4 is inverting (gain ~ -0.75): step A = TP4 down ~15 mV, step B = TP4 up ~30 mV.
* Default (trapezoidal) integration on purpose: Gear damping could hide ringing.
* Settling: max |V(tp4) - final| in windows starting 0.2/0.5/1/2/5 us after each edge.

.include sim3_levelshift_common.inc
.step param run 1 6 1
.param hv  = table(run, 1,50, 3,50, 4,120, 6,120)
.param v2  = table(run, 1,0, 2,1, 3,1, 4,0, 5,1, 6,1)
.param Cz  = table(run, 1,45e-12, 2,45e-12, 3,100e-12, 4,45e-12, 5,45e-12, 6,100e-12)

Vdac dac 0 PWL(0 0 2u 0 2.01u 20m 22u 20m 22.01u -20m 42u -20m)
X1 dac tp4 tp4r s fb g iq3 id5 irv ir29 vgs LS3 params: hvp={hv} v2p={v2}
Vsh fb s 0

.options plotwinsize=0
.tran 0 42u 0 2n

.meas TRAN v0   AVG V(tp4r) FROM 1u TO 2u
.meas TRAN v1   AVG V(tp4r) FROM 17u TO 22u
.meas TRAN v2f  AVG V(tp4r) FROM 37u TO 42u
.meas TRAN stepA PARAM v1-v0
.meas TRAN stepB PARAM v2f-v1
.meas TRAN minA MIN V(tp4r) FROM 2u TO 22u
.meas TRAN maxA MAX V(tp4r) FROM 2.01u TO 22u
.meas TRAN maxB MAX V(tp4r) FROM 22u TO 42u
.meas TRAN minB MIN V(tp4r) FROM 22.01u TO 42u
.meas TRAN ovsA_pct PARAM 100*(v1-minA)/(v0-v1)
.meas TRAN ovsB_pct PARAM 100*(maxB-v2f)/(v2f-v1)
.meas TRAN undA_pct PARAM 100*(maxA-v1)/(v0-v1)
.meas TRAN undB_pct PARAM 100*(v2f-minB)/(v2f-v1)
.meas TRAN devA_0u2 MAX abs(V(tp4r)-v1) FROM 2.21u TO 22u
.meas TRAN devA_0u5 MAX abs(V(tp4r)-v1) FROM 2.51u TO 22u
.meas TRAN devA_1u  MAX abs(V(tp4r)-v1) FROM 3.01u TO 22u
.meas TRAN devA_2u  MAX abs(V(tp4r)-v1) FROM 4.01u TO 22u
.meas TRAN devA_5u  MAX abs(V(tp4r)-v1) FROM 7.01u TO 22u
.meas TRAN devB_0u2 MAX abs(V(tp4r)-v2f) FROM 22.21u TO 42u
.meas TRAN devB_0u5 MAX abs(V(tp4r)-v2f) FROM 22.51u TO 42u
.meas TRAN devB_1u  MAX abs(V(tp4r)-v2f) FROM 23.01u TO 42u
.meas TRAN devB_2u  MAX abs(V(tp4r)-v2f) FROM 24.01u TO 42u
.meas TRAN devB_5u  MAX abs(V(tp4r)-v2f) FROM 27.01u TO 42u
.meas TRAN resA_pp PP V(tp4r) FROM 12u TO 22u
.meas TRAN resB_pp PP V(tp4r) FROM 32u TO 42u
.meas TRAN pre_pp  PP V(tp4r) FROM 0.5u TO 2u
.end
