* HVAWG -- SIM 3: level shifter alone -- 100 kHz sine fidelity at 90% of usable DAC swing
* Run:  LTspice.exe -b sim3_levelshift_tran100k.cir   Results: .meas + .four in sim3_levelshift_tran100k.log
* Same run table as sim3_levelshift.cir (1-3: +/-50 V V1 / V2 45p / V2 100p; 4-6: +/-120 V).
* DAC amplitude = 0.9 * V_TP3: 0.45 V (50 V rails, V_TP3 = 0.4995) / 1.08 V (120 V, V_TP3 = 1.1988).
* Ideal TP4 pk-pk = 0.75 * 2 * amp = 0.675 V (50 V) / 1.62 V (120 V).

.include sim3_levelshift_common.inc
.step param run 1 6 1
.param hv  = table(run, 1,50, 3,50, 4,120, 6,120)
.param v2  = table(run, 1,0, 2,1, 3,1, 4,0, 5,1, 6,1)
.param Cz  = table(run, 1,45e-12, 2,45e-12, 3,100e-12, 4,45e-12, 5,45e-12, 6,100e-12)
.param amp = table(run, 1,0.45, 3,0.45, 4,1.08, 6,1.08)

Vdac dac 0 SINE(0 {amp} 100k)
X1 dac tp4 tp4r s fb g iq3 id5 irv ir29 vgs LS3 params: hvp={hv} v2p={v2}
Vsh fb s 0

.options plotwinsize=0
.tran 0 100u 0 5n
.four 100k 9 2 V(tp4)

.meas TRAN pp     PP  V(tp4r) FROM 80u TO 100u
.meas TRAN tmax   MAX V(tp4r) FROM 80u TO 100u
.meas TRAN tmin   MIN V(tp4r) FROM 80u TO 100u
.meas TRAN gain   PARAM pp/(2*amp)
.meas TRAN iqmin  MIN V(iq3)  FROM 80u TO 100u
.meas TRAN iqmax  MAX V(iq3)  FROM 80u TO 100u
.meas TRAN vgsmin MIN V(vgs)  FROM 80u TO 100u
.meas TRAN vgsmax MAX V(vgs)  FROM 80u TO 100u
.meas TRAN id5max MAX V(id5)  FROM 80u TO 100u
.meas TRAN id5min MIN V(id5)  FROM 80u TO 100u
.meas TRAN ir29pk MAX abs(V(ir29)) FROM 80u TO 100u
.end
