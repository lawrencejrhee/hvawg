* SIM 2 baseline reproduction: class-A output stage, BSS126 (enhancement approximation), Rg1=1k
* Hand transcription of ../class-a-amplifier-test-bss126.asc (same parts, rails, source,
* .tran and .options). Only the Cload sweep is shortened to the two end points.
* Reference results from that file's log: Cload=2p -> +149.58/-148.16 V, Cload=20p -> +148.11/-148.14 V
*
* Node map: TP5 = drain / amplifier output, SRC = source (U1 -IN), G = gate, OA = opamp output,
*           NHV = -150 V rail, PHV = +150 V rail, VCC = -HV + 12 V (floating opamp supply)
*
XU1 IN SRC VCC NHV OA LM8261
M1 TP5 G SRC SRC BSS126
Rg1 OA G 1k
R3 SRC NHV 50
R2 PHV TP5 10k
V3 PHV 0 150
V_neg NHV 0 -150
V2 IN NHV SINE(0.75 0.75 100k)
V1 N12 NHV 12
R1 N12 VCC 1
C1 TP5 0 {Cload}
.param Cload=10p
.step param Cload list 2p 20p
.tran 0 50u 30u 5n
.options method=gear plotwinsize=0 gminsteps=500 cshunt=1e-12 itl4=500
.meas tran vout_pp pp V(TP5)
.meas tran vout_max max V(TP5)
.meas tran vout_min min V(TP5)
* BSS126 enhancement-mode approximation used by the project's earlier sims (the real BSS126 is depletion-mode)
.model BSS126 VDMOS(Vto=1.6 Kp=0.6 Lambda=0.005 Rs=0.4 Rd=10 Cgdmax=12p Cgdmin=2p Cgs=43p Cjo=17p Is=1e-13 mtriode=1.5 BV=600 IBV=10u Vds=600)
.lib C:\Users\lawre\AppData\Local\LTspice\lib\cmp\standard.mos
.include ../LM8261.MOD
.end
