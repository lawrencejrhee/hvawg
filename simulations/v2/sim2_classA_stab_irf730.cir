* SIM 2 stability check: class-A output stage, FET = IRF730 APPROXIMATE model, Rg1=1 ohm = as built (U7 drives the gate directly)
* Same circuit as sim2_classA_v2_irf730.cir, but the 100 kHz sine is replaced by a DC bias
* (VDC above -HV -> drain current VDC/50) with a +50 mV input step at 20 us and back at 35 us
* (about a 10 V output step). A stable stage settles flat; sustained oscillation shows up as
* peak-to-peak ripple in the flat windows (pre 12-20 us, post 28-35 us, end 43-50 us).
* VDC = 0.1 (2 mA, out ~+130 V), 0.75 (15 mA, out ~0 V), 1.4 (28 mA, out ~-130 V)
* VAR: 0 = baseline stage (+10Meg scope), 1 = + R28/D4 only, 3 = full V2 (R28/D4 + R31)
* Cload = 20p fixed (worst case of the 10p/20p range); Cz = 45p / 100p
*
.param VAR=3 Cload=20p Cz=45p Rg=1 VDC=0.75
.param ZEN={(VAR==1)+(VAR==3)}
.param R31ON={VAR>=2}
XU1 IN SRC VCC NHV OA LM8261
M1 TP5 G SRC SRC IRF730_APPROX
Rg1 OA G {Rg}
R3 SRC NHV 50
R2 PHV TP5 10k
* --- V2 gate protection. ZEN=0 removes it: R28 -> 1T, zener cut from G (1T) and shorted to SRC (1 ohm) ---
R28 G SRC {if(ZEN,100k,1T)}
RZS G DK {if(ZEN,1,1T)}
RZS2 DK SRC {if(ZEN,1T,1)}
D4 SRC DK DZ12
* --- V2 output series resistor (1 ohm when R31ON=0) and scope load at TP6 ---
R31 TP5 TP6 {if(R31ON,4.7k,1)}
C1 TP6 0 {Cload}
RSCOPE TP6 0 10Meg
V3 PHV 0 150
V_neg NHV 0 -150
V2 IN NHV PWL(0 {VDC} 20u {VDC} 20.02u {VDC+0.05} 35u {VDC+0.05} 35.02u {VDC})
V1 N12 NHV 12
R1 N12 VCC 1
.step param VAR list 0 1 3
.step param VDC list 0.1 0.75 1.4
.step param Cz list 45p 100p
.tran 0 50u 0 5n
.options method=gear plotwinsize=0 gminsteps=500 cshunt=1e-12 itl4=500
.meas tran pp_pre pp V(TP5) from 12u to 20u
.meas tran pp_post pp V(TP5) from 28u to 35u
.meas tran pp_end pp V(TP5) from 43u to 50u
.meas tran ppg_pre pp V(G) from 12u to 20u
.meas tran ppg_end pp V(G) from 43u to 50u
.meas tran pp6_end pp V(TP6) from 43u to 50u
.meas tran v_pre avg V(TP5) from 15u to 20u
.meas tran v_post avg V(TP5) from 30u to 35u
.meas tran vmin_step min V(TP5) from 20u to 28u
.meas tran over_pct param 100*(v_post-vmin_step)/(v_pre-v_post)
.meas tran vmax_ret max V(TP5) from 35u to 43u
.meas tran over2_pct param 100*(vmax_ret-v_pre)/(v_pre-v_post)
.model DZ12 D(Is=1e-14 Rs=5 BV=12 Ibv=5m Cjo={Cz} M=0.4 Vj=0.75)
* IRF730 is NOT in LTspice's library. APPROXIMATION built from typical datasheet values:
* 400 V, Rds(on) ~0.85 ohm @10 V (1.0 max), Vth ~3.5 V (2-4 V spec), Kp=2 (Id=Kp/2*(Vgs-Vto)^2, gfs ~2.9 S class),
* Ciss ~670p, Crss ~50p at Vds>>0 (64p @25V spec), Coss ~170p @25V, Qg ~38n. Not a vendor model.
.model IRF730_APPROX VDMOS(Rg=2 Vto=3.5 Kp=2 Lambda=0.003 Rd=0.7 Rs=0.05 Rb=0.2 Cgdmax=0.8n Cgdmin=50p A=1 Cgs=620p Cjo=640p M=0.5 Vj=0.7 Is=20p BV=400 IBV=250u ksubthres=0.1 mfg=approximation Vds=400 Ron=1 Qg=38n)
.lib C:\Users\lawre\AppData\Local\LTspice\lib\cmp\standard.mos
.include ../LM8261.MOD
.end
