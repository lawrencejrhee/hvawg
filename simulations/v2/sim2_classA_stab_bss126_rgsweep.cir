* SIM 2 stability follow-up: BSS126 approximation, gate-stopper (Rg1) sweep and R31 attribution
* Same circuit as sim2_classA_v2_bss126.cir, but the 100 kHz sine is replaced by a DC bias
* (VDC above -HV -> drain current VDC/50) with a +50 mV input step at 20 us and back at 35 us
* (about a 10 V output step). A stable stage settles flat; sustained oscillation shows up as
* peak-to-peak ripple in the flat windows (pre 12-20 us, post 28-35 us, end 43-50 us).
* VDC = 0.1 (2 mA, out ~+130 V), 0.75 (15 mA, out ~0 V), 1.4 (28 mA, out ~-130 V)
* VAR: 0 = baseline stage (+10Meg scope), 2 = + R31 only, 3 = full V2 (R28/D4 + R31); Rg1 stepped 330 / 1k / 3.3k
* Cload = 20p, Cz = 100p fixed
*
.param VAR=3 Cload=20p Cz=100p Rg=1k VDC=0.75
.param ZEN={(VAR==1)+(VAR==3)}
.param R31ON={VAR>=2}
XU1 IN SRC VCC NHV OA LM8261
M1 TP5 G SRC SRC BSS126
Rg1 OA G {Rg}
R3 SRC NHV 50
R2 PHV TP5 10k
* --- V2 gate protection. ZEN=0 removes it: R28 -> 1T, zener cut from G (1T) and shorted to SRC (1 ohm) ---
R28 G SRC {if(ZEN,100k,1T)}
RZS G DK {if(ZEN,1,1T)}
RZS2 DK SRC {if(ZEN,1T,1)}
D4 SRC DK DZ12
* --- V2 output series resistor (1 ohm when R31ON=0) and scope load at TP6 ---
R31 TP5 TP6 {if(R31ON,4.7k,1)}
C1 TP6 0 {Cload}
RSCOPE TP6 0 10Meg
V3 PHV 0 150
V_neg NHV 0 -150
V2 IN NHV PWL(0 {VDC} 20u {VDC} 20.02u {VDC+0.05} 35u {VDC+0.05} 35.02u {VDC})
V1 N12 NHV 12
R1 N12 VCC 1
.step param VAR list 0 2 3
.step param VDC list 0.1 0.75 1.4
.step param Rg list 330 1k 3.3k
.tran 0 50u 0 5n
.options method=gear plotwinsize=0 gminsteps=500 cshunt=1e-12 itl4=500
.meas tran pp_pre pp V(TP5) from 12u to 20u
.meas tran pp_post pp V(TP5) from 28u to 35u
.meas tran pp_end pp V(TP5) from 43u to 50u
.meas tran ppg_pre pp V(G) from 12u to 20u
.meas tran ppg_end pp V(G) from 43u to 50u
.meas tran pp6_end pp V(TP6) from 43u to 50u
.meas tran v_pre avg V(TP5) from 15u to 20u
.meas tran v_post avg V(TP5) from 30u to 35u
.meas tran vmin_step min V(TP5) from 20u to 28u
.meas tran over_pct param 100*(v_post-vmin_step)/(v_pre-v_post)
.meas tran vmax_ret max V(TP5) from 35u to 43u
.meas tran over2_pct param 100*(vmax_ret-v_pre)/(v_pre-v_post)
.model DZ12 D(Is=1e-14 Rs=5 BV=12 Ibv=5m Cjo={Cz} M=0.4 Vj=0.75)
* BSS126 enhancement-mode approximation used by the project's earlier sims (the real BSS126 is depletion-mode)
.model BSS126 VDMOS(Vto=1.6 Kp=0.6 Lambda=0.005 Rs=0.4 Rd=10 Cgdmax=12p Cgdmin=2p Cgs=43p Cjo=17p Is=1e-13 mtriode=1.5 BV=600 IBV=10u Vds=600)
.lib C:\Users\lawre\AppData\Local\LTspice\lib\cmp\standard.mos
.include ../LM8261.MOD
.end
